`include "disciplines.vams"

module laser_noise_model(opt_out);
    electrical opt_out;
    ground gnd;

    parameter real f0 = 674e-9;     // comprimento de onda (m)
    parameter real linewidth = 1.5e3; // Hz
    parameter real P0 = 1e-3;       // potência média (W)

    real omega0, phi, dphi, dt, phase_noise;
    integer seed;

    analog begin
        @(initial_step) begin
            seed = 12345;
            omega0 = 2 * `M_PI * `C / f0;
            phi = 0.0;
        end
        dt = `ABSOLUTETIME_STEP;
        // Ruído de fase: incremento de Wiener com variância 2π * linewidth * dt
        dphi = sqrt(2 * `M_PI * linewidth * dt) * $rdist_normal(seed, 0, 1);
        phi = phi + dphi;
        phase_noise = phi;
        // Sinal óptico: campo E = sqrt(P0) * cos(omega0*t + phase_noise)
        V(opt_out) <+ sqrt(P0) * cos(omega0 * $abstime + phase_noise);
    end
endmodule
